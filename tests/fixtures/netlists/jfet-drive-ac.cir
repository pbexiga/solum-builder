* Example JFET drive
V_RAIL1 v_ 0 DC 16
V_IN c1_1 0 DC 0 AC 1
C1 c1_1 q1_g 2.2e-08
R1 q1_g 0 1000000
J_Q1 q1_d q1_g q1_s J201_Q1
R_TR1_a v_ q1_d 25000
R_TR1_b q1_d tr1_3 25000
R2 q1_s 0 1500
C2 q1_d c2_2 1e-06
R_VR1_a c2_2 out 46000
R_VR1_b out 0 54000
R_OUT out 0 1000000
* J201 low-pinch-off N-channel JFET (our model from Fairchild's and InterFET's sheets)
* Built by Solum Builder from Fairchild J201/J202 data sheet (1997); InterFET J201/J202 data sheet IF35018.R00 (June 2019) (D-161)
.model J201 NJF(vto=-0.6708 beta=0.0009938 lambda=0.002236 cgs=3e-12 cgd=1e-12)
.model J201_Q1 NJF(vto=-0.8 beta=0.0009375 lambda=0.002236 cgs=3e-12 cgd=1e-12)
.ac dec 50 10 100000
.end
