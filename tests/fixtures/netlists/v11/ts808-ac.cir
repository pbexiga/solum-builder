* Ibanez TS808 Tube Screamer
V_RAIL1 v_ 0 DC 9
R33 v_ vref 10000
R32 vref 0 10000
C16 vref 0 4.7e-05
C17 v_ 0 0.0001
V_IN in 0 DC 0 AC 0.999996000016
C1 in c1_2 2e-08
R1 c1_2 q1_b 1000
R2 vref q1_b 510000
Q1 v_ q1_b q1e 2SC1815
R3 q1e 0 10000
C2 q1e u2__ 1e-06
R5 u2__ vref 10000
X_U2 u2__ u2___2 v_ 0 u2o RC4558
R4 0 c3_1 4700
C3 c3_1 u2___2 4.7e-08
R6 u2___2 p1_1 51000
R_P1_a p1_1 u2o 50000
R_P1_b u2o p1_3 450000
D1 u2o u2___2 1N4148
D2 u2___2 u2o 1N4148
C4 u2___2 u2o 5.1e-11
R8 u2o u1__ 1000
C5 u1__ 0 2.2e-07
R9 u1__ vref 10000
R_P2_a u1__ c6_1 10000
R_P2_b c6_1 u1___2 10000
C6 c6_1 c6_2 2.2e-07
R10 c6_2 0 220
X_U1 u1__ u1___2 v_ 0 u1_out RC4558
R11 u1___2 u1_out 1000
C7 u1_out c7_2 1e-06
R12 c7_2 p3_3 1000
R_P3_a 0 c8_1 100000
R_P3_b c8_1 p3_3 1
C8 c8_1 q3_b 1e-07
R13 vref q3_b 510000
Q3 v_ q3_b q3_e 2SC1815
R14 q3_e 0 10000
RB q3_e c9_1 100
C9 c9_1 out 1e-05
RC out 0 10000
R_AMP out 0 1000000
* 1N4148 small-signal silicon diode (our fit to Diotec's and onsemi's sheets)
* Fitted by Solum Builder to Diotec 1N4148, 1N4150, 1N4151, 1N4448 data sheet, Version 2023-08-17, Forward characteristics (typical values), Tj = 25 °C, from 2.4 mA (read from the PDF's vector drawing, centre of the drawn line) (D-156)
.model 1N4148 D(is=2.32e-09 n=1.797 rs=0.2449 cjo=4e-12 bv=100 ibv=0.0001)
* 2SC1815 general-purpose audio NPN (Toshiba; hFE 70-700 in grades O, Y, GR, BL), our fit to Toshiba's sheet
* Fitted by Solum Builder to Toshiba 2SC1815 data sheet (1997-04-10, 3 pages), its typical curves (D-163)
.model 2SC1815 NPN(is=1.064e-13 nf=1.021 bf=152.7 ise=3.655e-14 ne=1.42 ikf=1.098 br=5.828 isc=3.375e-12 nc=1.41 rc=0.8201 vje=0.75 mje=0.33 cjc=4.815e-12 vjc=0.75 mjc=0.33 tf=1.029e-09 nkf=1 nr=1.021 rb=50)
* RC4558 dual op-amp (TI 1989 macromodel; stands in for the TS808's JRC4558)
* Source: https://github.com/kicad-spice-library/KiCad-Spice-Library/blob/a8688952bcaab19f567bc4db237b60bde03ef310/Models/Manufacturer/Texas%20Instruments/rc4558.mod
* RC4558 operational amplifier "macromodel" subcircuit
* created using Parts release 4.01 on 09/08/89 at 16:07
* (REV N/A)
* connections:   non-inverting input
*                | inverting input
*                | | positive power supply
*                | | | negative power supply
*                | | | | output
*                | | | | |
.subckt RC4558	 1 2 3 4 5
*
  c1   11 12 2.664E-12
  c2    6  7 20.00E-12
  dc    5 53 dx
  de   54  5 dx
  dlp  90 91 dx
  dln  92 90 dx
  dp    4  3 dx
  egnd 99  0 poly(2) (3,0) (4,0) 0 .5 .5
  fb    7 99 poly(5) vb vc ve vlp vln 0 6.365E6 -6E6 6E6 6E6 -6E6
  ga	6  0 11 12 418.0E-6
  gcm   0  6 10 99 6.705E-9
  iee   3 10 dc 34.28E-6
  hlim 90  0 vlim 1K
  q1   11  2 13 qx
  q2   12  1 14 qx
  r2    6  9 100.0E3
  rc1   4 11 2.652E3
  rc2   4 12 2.652E3
  re1  13 10 1.122E3
  re2  14 10 1.122E3
  ree  10 99 5.834E6
  ro1	8  5 125
  ro2	7 99 125
  rp    3  4 24.67E3
  vb    9  0 dc 0
  vc    3 53 dc 2.600
  ve   54  4 dc 2.600
  vlim  7  8 dc 0
  vlp  91  0 dc 25
  vln   0 92 dc 25
.model dx D(is=800.0E-18)
.model qx PNP(is=800.0E-18 bf=121.4)
.ends

.ac dec 50 10 100000
.end
